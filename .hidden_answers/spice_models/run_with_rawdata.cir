* AEROTONE VOICE CARD - RAW WAVEFORM OUTPUT
* Outputs full transient data for comparison

* === POWER SUPPLIES ===
V_supply vcc 0 DC 12
V_logic vdd 0 DC 15

* === INPUT SIGNALS ===
V_pd pd_in 0 DC 7.5 SIN(0 0.5 220)
V_pickup pickup 0 SIN(0 0.05 220)

* ============================================================
* HEALTHY CIRCUIT
* ============================================================
R3_h pd_in lf_h 100k
C2_h lf_h 0 10u IC=7.5

E_drv_h drv_h 0 lf_h 0 0.88
R_mot_h drv_h mot_h 2
V_bemf_h mot_h i_sense_h 5.75
V_isense_h i_sense_h 0 DC 0

E_amp_h amp_h 0 pickup 0 101
B_cond_h cond_h 0 V=min(max(V(amp_h),-12),12)

* ============================================================
* F001: LEAKY CAPACITOR C2 (30k leakage to ground)
* ============================================================
R3_f1 pd_in lf_f1 100k
C2_f1 lf_f1 leak_f1 10u IC=7.5
R_leak_f1 leak_f1 0 30k

E_drv_f1 drv_f1 0 lf_f1 0 0.88
R_mot_f1 drv_f1 mot_f1 2
V_bemf_f1 mot_f1 i_sense_f1 DC 5.75
V_isense_f1 i_sense_f1 0 DC 0

E_amp_f1 amp_f1 0 pickup 0 101
B_cond_f1 cond_f1 0 V=min(max(V(amp_f1),-12),12)

* ============================================================
* F002: BURNED TRANSISTOR Q1 (100 ohm series resistance)
* ============================================================
R3_f2 pd_in lf_f2 100k
C2_f2 lf_f2 0 10u IC=7.5

E_drv_f2 drv_f2_raw 0 lf_f2 0 0.88
R_damage_f2 drv_f2_raw drv_f2 100
R_mot_f2 drv_f2 mot_f2 2
V_bemf_f2 mot_f2 i_sense_f2 DC 3.5
V_isense_f2 i_sense_f2 0 DC 0

E_amp_f2 amp_f2 0 pickup 0 101
B_cond_f2 cond_f2 0 V=min(max(V(amp_f2),-12),12)

* ============================================================
* F003: NOISY OP-AMP U2 (15kHz oscillation added)
* ============================================================
R3_f3 pd_in lf_f3 100k
C2_f3 lf_f3 0 10u IC=7.5

E_drv_f3 drv_f3 0 lf_f3 0 0.88
R_mot_f3 drv_f3 mot_f3 2
V_bemf_f3 mot_f3 i_sense_f3 DC 5.75
V_isense_f3 i_sense_f3 0 DC 0

E_amp_f3 amp_f3a 0 pickup 0 101
V_noise_f3 noise_f3 0 SIN(0 3 15000)
B_cond_f3 cond_f3 0 V=min(max(V(amp_f3a)+V(noise_f3),-14),14)

* ============================================================
* F004: OPEN FEEDBACK RESISTOR R9 (infinite gain = saturation)
* ============================================================
R3_f4 pd_in lf_f4 100k
C2_f4 lf_f4 0 10u IC=7.5

E_drv_f4 drv_f4 0 lf_f4 0 0.88
R_mot_f4 drv_f4 mot_f4 2
V_bemf_f4 mot_f4 i_sense_f4 DC 5.75
V_isense_f4 i_sense_f4 0 DC 0

B_cond_f4 cond_f4 0 V=12*sgn(V(pickup)+1e-6)

* ============================================================
* F005: SHORTED DIODE D2 (5 ohm parallel path)
* ============================================================
R3_f5 pd_in lf_f5 100k
C2_f5 lf_f5 0 10u IC=7.5

E_drv_f5 drv_f5 0 lf_f5 0 0.88
R_short_f5 drv_f5 i_sense_f5a 5
R_mot_f5 drv_f5 mot_f5 2
V_bemf_f5 mot_f5 i_sense_f5b DC 4.0
V_isense_f5a i_sense_f5a 0 DC 0
V_isense_f5b i_sense_f5b 0 DC 0

E_amp_f5 amp_f5 0 pickup 0 101
B_cond_f5 cond_f5 0 V=min(max(V(amp_f5),-12),12)

* ============================================================
* ANALYSIS - OUTPUT RAW DATA
* ============================================================
.control
set filetype=ascii
tran 10u 50m UIC

* Write raw data to files
wrdata healthy_raw.dat v(lf_h) v(drv_h) i(V_isense_h) v(cond_h)
wrdata f001_raw.dat v(lf_f1) v(drv_f1) i(V_isense_f1) v(cond_f1)
wrdata f002_raw.dat v(lf_f2) v(drv_f2) i(V_isense_f2) v(cond_f2)
wrdata f003_raw.dat v(lf_f3) v(drv_f3) i(V_isense_f3) v(cond_f3)
wrdata f004_raw.dat v(lf_f4) v(drv_f4) i(V_isense_f4) v(cond_f4)
wrdata f005_raw.dat v(lf_f5) v(drv_f5) i(V_isense_f5a) i(V_isense_f5b) v(cond_f5)

echo "Raw data files written successfully"
.endc
.end
