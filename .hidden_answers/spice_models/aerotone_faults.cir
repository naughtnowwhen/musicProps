* AEROTONE MODEL 12 - FAULT INJECTION SIMULATION
* Real component models with 5 fault scenarios

.INCLUDE real_components.lib

*==============================================================
* POWER SUPPLIES
*==============================================================
V_SUPPLY vcc 0 DC 12
V_LOGIC vdd 0 DC 15

*==============================================================
* REFERENCE & TACHOMETER
*==============================================================
V_REF ref_in 0 PULSE(0 15 0 10N 10N 2.27M 4.545M)
V_TACH tach_raw 0 SIN(0 50M 220 0 0)

*==============================================================
* SIGNAL CONDITIONER (U2: LM358)
*==============================================================
R_VG1 vdd vgnd 10K
R_VG2 vgnd 0 10K
C_BIAS vgnd 0 10U IC=7.5

C_AC tach_raw tach_ac 1U
R8 tach_ac opamp_inn 1K

* R9 - FAULT F004 INJECTION POINT
* Normal: 100K, F004 (open): 100MEG
* Feedback must go to actual op-amp output (cond_pre), not through noise injection
.PARAM R9_VAL = 100K
R9 opamp_inn cond_pre {R9_VAL}

* U2 Op-Amp - FAULT F003 INJECTION POINT
* F003 adds 15kHz noise oscillation
* Using National Semiconductor LM358 model (ngspice compatible)
X_U2 vgnd opamp_inn vdd 0 cond_pre LM358
* Noise injection for F003
.PARAM NOISE_AMP = 0
V_NOISE noise_src 0 SIN(0 {NOISE_AMP} 15000)
B_COND cond_out 0 V=V(cond_pre)+V(noise_src)

X_C3 vdd 0 CAP_CER_100N

*==============================================================
* COMPARATOR (CMOS Schmitt trigger style)
* Converts conditioned signal to digital levels
*==============================================================
* Simple CMOS comparator using inverter with threshold at vgnd
X_COMP_INV1 cond_out comp_int vdd 0 CMOS_INV
X_COMP_INV2 comp_int comp_out vdd 0 CMOS_INV

*==============================================================
* CD4046 PHASE COMPARATOR (Real CMOS)
* Uses Phase Comparator I (XOR type) for frequency/phase detection
*==============================================================
X_PC1 ref_in comp_out vdd 0 pd_out CD4046_PC1

*==============================================================
* LOOP FILTER (R3 + C2)
* C2 - FAULT F001 INJECTION POINT
*==============================================================
R3 pd_out loop_filt 100K

* C2 with ESR and leakage
* Normal: no leakage, F001: 30k leakage resistor
.PARAM C2_LEAK = 100MEG
X_C2 loop_filt c2_mid CAP_ELEC_10U
R_C2_LEAK c2_mid 0 {C2_LEAK}

*==============================================================
* H-BRIDGE MOTOR DRIVER
*==============================================================
R_DRIVE1 loop_filt base_q1 1K
R_DRIVE2 loop_filt base_q2 1K
R_BIAS1 vcc base_q1 4.7K
R_BIAS2 base_q2 0 4.7K

* Q1 - FAULT F002 INJECTION POINT
* Normal: working transistor, F002: high series resistance (burned)
.PARAM Q1_DAMAGE = 0
Q1 vcc base_q1 q1_emit 2N3055
R_Q1_DAMAGE q1_emit motor_p {0.01 + Q1_DAMAGE}

Q2 motor_n base_q2 0 MJ2955

R_DRIVE3 loop_filt base_q3 1K
R_DRIVE4 loop_filt base_q4 1K
R_BIAS3 vcc base_q3 4.7K
R_BIAS4 base_q4 0 4.7K

Q3 vcc base_q3 motor_n 2N3055
Q4 motor_p base_q4 0 MJ2955

* FLYBACK DIODES
* D2 - FAULT F005 INJECTION POINT
* Normal: diode, F005: shorted (low resistance)
.PARAM D2_SHORT = 100MEG
D1 motor_p vcc 1N4001
D2 0 motor_p 1N4001
R_D2_SHORT 0 motor_p {D2_SHORT}
D3 motor_n vcc 1N4001
D4 0 motor_n 1N4001

*==============================================================
* MOTOR
*==============================================================
R_MOTOR motor_p motor_bemf 20
V_BEMF motor_bemf motor_n DC 0
R_SENSE motor_n motor_gnd 0.1
V_SENSE motor_gnd 0 DC 0

*==============================================================
* ANALYSIS
*==============================================================
.OPTIONS RELTOL=0.01 ABSTOL=1N VNTOL=1M ITL1=500 ITL4=100

.CONTROL
set filetype=ascii

* === HEALTHY CIRCUIT ===
alterparam R9_VAL = 100K
alterparam NOISE_AMP = 0
alterparam C2_LEAK = 100MEG
alterparam Q1_DAMAGE = 0
alterparam D2_SHORT = 100MEG
reset
TRAN 1U 100M UIC
WRDATA fault_healthy.dat V(loop_filt) V(motor_p,motor_n) I(V_SENSE) V(cond_out) V(cond_pre) V(opamp_inn) V(vgnd) V(tach_ac)
ECHO "Healthy simulation complete"

* === F001: LEAKY CAPACITOR C2 ===
* Very severe leakage (3K) to make fault diagnosable
alterparam C2_LEAK = 3K
reset
TRAN 1U 100M UIC
WRDATA fault_f001.dat V(loop_filt) V(motor_p,motor_n) I(V_SENSE) V(cond_out)
ECHO "F001 (Leaky C2) simulation complete"
alterparam C2_LEAK = 100MEG

* === F002: BURNED TRANSISTOR Q1 ===
alterparam Q1_DAMAGE = 100
reset
TRAN 1U 100M UIC
WRDATA fault_f002.dat V(loop_filt) V(motor_p,motor_n) I(V_SENSE) V(cond_out)
ECHO "F002 (Burned Q1) simulation complete"
alterparam Q1_DAMAGE = 0

* === F003: NOISY OP-AMP U2 ===
alterparam NOISE_AMP = 3
reset
TRAN 1U 100M UIC
WRDATA fault_f003.dat V(loop_filt) V(motor_p,motor_n) I(V_SENSE) V(cond_out)
ECHO "F003 (Noisy U2) simulation complete"
alterparam NOISE_AMP = 0

* === F004: OPEN RESISTOR R9 ===
alterparam R9_VAL = 100MEG
reset
TRAN 1U 100M UIC
WRDATA fault_f004.dat V(loop_filt) V(motor_p,motor_n) I(V_SENSE) V(cond_out)
ECHO "F004 (Open R9) simulation complete"
alterparam R9_VAL = 100K

* === F005: SHORTED DIODE D2 ===
alterparam D2_SHORT = 5
reset
TRAN 1U 100M UIC
WRDATA fault_f005.dat V(loop_filt) V(motor_p,motor_n) I(V_SENSE) V(cond_out)
ECHO "F005 (Shorted D2) simulation complete"

ECHO ""
ECHO "All fault simulations complete!"

.ENDC
.END
