* SPICE→AUDIO: Fast simulation for audio generation
.INCLUDE real_components.lib

*==============================================================
* POWER SUPPLIES
*==============================================================
V_SUPPLY vcc 0 DC 12
V_LOGIC vdd 0 DC 15

*==============================================================
* REFERENCE (sets target frequency)
*==============================================================
V_REF ref_in 0 PULSE(0 15 0 10N 10N 0.0022727272727272726 0.004545454545454545)

* Tachometer feedback (simplified - just tracks motor)
V_TACH tach_raw 0 SIN(0 50M 220 0 0)

*==============================================================
* SIGNAL CONDITIONER
*==============================================================
R_VG1 vdd vgnd 10K
R_VG2 vgnd 0 10K
C_BIAS vgnd 0 10U IC=7.5

C_AC tach_raw tach_ac 1U
R8 tach_ac opamp_inn 1K
R9 opamp_inn cond_pre 100K

X_U2 vgnd opamp_inn vdd 0 cond_pre LM358
B_COND cond_out 0 V=V(cond_pre)

X_C3 vdd 0 CAP_CER_100N

*==============================================================
* COMPARATOR & PLL
*==============================================================
X_COMP_INV1 cond_out comp_int vdd 0 CMOS_INV
X_COMP_INV2 comp_int comp_out vdd 0 CMOS_INV

X_PC1 ref_in comp_out vdd 0 pd_out CD4046_PC1

*==============================================================
* LOOP FILTER
*==============================================================
R3 pd_out loop_filt 100K
X_C2 loop_filt c2_mid CAP_ELEC_10U
R_C2_LEAK c2_mid 0 100MEG

*==============================================================
* H-BRIDGE DRIVER
*==============================================================
R_DRIVE1 loop_filt base_q1 1K
R_DRIVE2 loop_filt base_q2 1K
R_BIAS1 vcc base_q1 4.7K
R_BIAS2 base_q2 0 4.7K

Q1 vcc base_q1 q1_emit 2N3055
R_Q1_DAMAGE q1_emit motor_p 0.01
Q2 motor_n base_q2 0 MJ2955

R_DRIVE3 loop_filt base_q3 1K
R_DRIVE4 loop_filt base_q4 1K
R_BIAS3 vcc base_q3 4.7K
R_BIAS4 base_q4 0 4.7K

Q3 vcc base_q3 motor_n 2N3055
Q4 motor_p base_q4 0 MJ2955

D1 motor_p vcc 1N4001
D2 0 motor_p 1N4001
D3 motor_n vcc 1N4001
D4 0 motor_n 1N4001

*==============================================================
* MOTOR (simple resistive model)
* Mechanical dynamics calculated in Python from loop_filt
*==============================================================
R_MOTOR motor_p motor_bemf 20.0
V_BEMF motor_bemf motor_n DC 0
R_SENSE motor_n motor_gnd 0.1
V_SENSE motor_gnd 0 DC 0

*==============================================================
* FAST SIMULATION OPTIONS
*==============================================================
* Looser tolerances = faster convergence
.OPTIONS RELTOL=0.05 ABSTOL=10N VNTOL=10M
.OPTIONS ITL1=200 ITL4=50

.CONTROL
set filetype=ascii

* Larger timestep for speed (10µs instead of 1µs)
TRAN 10U 2000M UIC

* Save motor signals AND loop filter (control voltage)
WRDATA spice_audio_motor.dat V(motor_p,motor_n) I(V_SENSE) V(loop_filt) V(cond_out)

ECHO "Fast simulation complete"
.ENDC
.END
